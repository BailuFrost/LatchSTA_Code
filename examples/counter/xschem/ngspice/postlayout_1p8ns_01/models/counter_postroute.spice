* Distributed routed interconnect; pin capacitance supplied by native MOS devices.
.subckt counter_postroute clk rst_n en VPWR VGND q3 q2 q1 q0
X_07_ n0003 n0004 n0005 VGND VGND VPWR VPWR n0006 sky130_fd_sc_hd__o21ai_0
X_08_ n0007 n0008 n0009 VGND VGND VPWR VPWR n0010 sky130_fd_sc_hd__a21oi_1
X_09_ n0011 n0012 n0013 VGND VGND VPWR VPWR n0014 sky130_fd_sc_hd__and3_1
X_10_ n0015 n0016 n0017 VGND VGND VPWR VPWR n0018 sky130_fd_sc_hd__o21ai_0
X_11_ n0019 n0020 n0021 VGND VGND VPWR VPWR n0022 sky130_fd_sc_hd__a21oi_1
X_12_ n0023 n0024 n0025 n0026 n0027 VGND VGND VPWR VPWR n0028 sky130_fd_sc_hd__a41o_1
X_13_ n0029 n0030 VGND VGND VPWR VPWR n0031 sky130_fd_sc_hd__nand2_1
X_14_ n0032 n0033 n0034 n0035 VGND VGND VPWR VPWR n0036 sky130_fd_sc_hd__a31oi_1
X_15_ n0037 n0038 n0039 VGND VGND VPWR VPWR n0040 sky130_fd_sc_hd__a21oi_1
X_16_ n0041 n0042 n0043 VGND VGND VPWR VPWR n0044 sky130_fd_sc_hd__nor3b_1
X_17_ _00_[0] ckm[0] VGND VGND VPWR VPWR master[0] sky130_fd_sc_hd__dlxtn_1
X_18_ _00_[1] ckm[1] VGND VGND VPWR VPWR master[1] sky130_fd_sc_hd__dlxtn_1
X_19_ _00_[2] ckm[2] VGND VGND VPWR VPWR master[2] sky130_fd_sc_hd__dlxtn_1
X_20_ _00_[3] ckm[3] VGND VGND VPWR VPWR master[3] sky130_fd_sc_hd__dlxtn_1
X_21_ n0057 cks[0] VGND VGND VPWR VPWR slave[0] sky130_fd_sc_hd__dlxtp_1
X_22_ n0060 cks[1] VGND VGND VPWR VPWR slave[1] sky130_fd_sc_hd__dlxtp_1
X_23_ n0063 cks[2] VGND VGND VPWR VPWR slave[2] sky130_fd_sc_hd__dlxtp_1
X_24_ n0066 cks[3] VGND VGND VPWR VPWR slave[3] sky130_fd_sc_hd__dlxtp_1
Xclkbuf_0_clk n0071 VGND VGND VPWR VPWR clk_root_out sky130_fd_sc_hd__clkbuf_4
Xclkbuf_1_0__f_clk n0073 VGND VGND VPWR VPWR clk_leaf0_out sky130_fd_sc_hd__clkbuf_4
Xclkbuf_1_1__f_clk n0075 VGND VGND VPWR VPWR clk_leaf1_out sky130_fd_sc_hd__clkbuf_4
Xclkload0 n0077 VGND VGND VPWR VPWR dummy_clkload0_x sky130_fd_sc_hd__clkbuf_1
Rwire0 n0010 _00_[0] 37.0476
Rwire1 n0044 _00_[1] 35.069
Rwire2 n0022 _00_[2] 33.1026
Rwire3 n0036 _00_[3] 42.6646
Rwire4 n0006 n0009 33.8821
Rwire5 n0014 n0000 22.1896
Rwire6 n0000 n0041 9.24915
Rwire7 n0000 n0001 9.71037
Rwire8 n0001 n0016 17.6796
Rwire9 n0001 n0002 6.332
Rwire10 n0002 n0020 13.8789
Rwire11 n0002 n0034 19.9795
Rwire12 n0018 n0021 34.4877
Rwire13 n0028 n0030 42.11
Rwire14 n0031 n0035 20.355
Rwire15 n0040 n0042 41.3359
Rwire16 clk n0070 23.8335
Rwire17 n0070 n0071 15.5817
Rwire18 clk_root_out n0078 16.1605
Rwire19 n0078 n0079 19.6115
Rwire20 n0079 n0073 11.6183
Rwire21 n0078 n0080 19.3583
Rwire22 n0080 n0075 11.0998
Rwire23 clk_leaf0_out n0084 17.2421
Rwire24 n0084 n0081 8.55102
Rwire25 n0081 n0082 1.8326
Rwire26 n0082 ckm[0] 15.398
Rwire27 n0082 n0083 13.3913
Rwire28 n0083 cks[1] 14.4725
Rwire29 n0083 cks[2] 19.9785
Rwire30 n0081 cks[0] 10.2378
Rwire31 n0084 n0077 17.6896
Rwire32 clk_leaf1_out n0087 15.9964
Rwire33 n0087 n0085 7.993
Rwire34 n0085 n0086 5.18434
Rwire35 n0086 ckm[2] 11.1059
Rwire36 n0086 ckm[1] 22.1574
Rwire37 n0085 cks[3] 12.191
Rwire38 n0087 ckm[3] 13.7491
Rwire39 en n0093 16.3094
Rwire40 n0093 n0003 9.24915
Rwire41 n0093 n0094 3.13472
Rwire42 n0094 n0011 10.9732
Rwire43 n0094 n0095 5.18434
Rwire44 n0095 n0007 9.82786
Rwire45 n0095 n0096 9.54971
Rwire46 n0096 n0024 13.7491
Rwire47 n0096 n0037 23.687
Rwire48 master[0] n0057 22.2117
Rwire49 master[1] n0060 31.7363
Rwire50 master[2] n0063 33.826
Rwire51 master[3] n0066 31.5781
Rwire52 rst_n n0100 9.54735
Rwire53 n0100 n0005 13.7491
Rwire54 n0100 n0098 4.2258
Rwire55 n0098 n0099 8.48154
Rwire56 n0099 n0029 41.4452
Rwire57 n0099 n0017 10.5513
Rwire58 n0098 n0043 15.6056
Rwire59 slave[0] n0101 18.6595
Rwire60 n0101 n0102 11.8786
Rwire61 n0102 n0103 3.85811
Rwire62 n0103 n0013 9.24915
Rwire63 n0103 n0004 13.9512
Rwire64 n0102 n0008 9.82786
Rwire65 n0101 n0104 2.45487
Rwire66 n0104 q0 5.86303
Rwire67 n0104 n0038 18.5884
Rwire68 n0104 n0026 17.8002
Rwire69 slave[1] n0106 13.7491
Rwire70 n0106 n0107 3.493
Rwire71 n0107 n0012 25.73
Rwire72 n0107 n0025 15.5817
Rwire73 n0106 n0105 0.793864
Rwire74 n0105 q1 6.35855
Rwire75 n0105 n0039 15.2664
Rwire76 slave[2] n0108 23.2301
Rwire77 n0108 n0109 30.928
Rwire78 n0109 n0019 22.1896
Rwire79 n0109 n0015 9.24915
Rwire80 n0108 n0023 14.4725
Rwire81 slave[2] n0110 11.6605
Rwire82 n0110 q2 17.1858
Rwire83 n0110 n0032 9.24915
Rwire84 slave[3] n0111 21.8207
Rwire85 n0111 n0112 0.202865
Rwire86 n0112 n0027 26.7795
Rwire87 n0112 n0033 17.4965
Rwire88 n0111 q3 2.2814
Cg0 _00_[0] VGND 0.000320471p
Cg1 n0010 VGND 0.000320471p
Cg2 _00_[1] VGND 0.000265236p
Cg3 n0044 VGND 0.000265236p
Cg4 _00_[2] VGND 0.000289312p
Cg5 n0022 VGND 0.000289312p
Cg6 _00_[3] VGND 0.000606039p
Cg7 n0036 VGND 0.000606039p
Cg8 n0009 VGND 0.000264576p
Cg9 n0006 VGND 0.000264576p
Cg10 n0034 VGND 0.000315035p
Cg11 n0020 VGND 0.000201775p
Cg12 n0016 VGND 0.000222854p
Cg14 n0014 VGND 0.00013479p
Cg15 n0002 VGND 0.000582251p
Cg16 n0001 VGND 0.000456222p
Cg17 n0000 VGND 0.000302717p
Cg18 n0021 VGND 0.000248891p
Cg19 n0018 VGND 0.000248891p
Cg20 n0030 VGND 0.000828162p
Cg21 n0028 VGND 0.000828162p
Cg22 n0035 VGND 2.94076e-05p
Cg23 n0031 VGND 2.94076e-05p
Cg24 n0042 VGND 0.000369786p
Cg25 n0040 VGND 0.000369786p
Cg26 clk VGND 0.00250386p
Cg27 n0071 VGND 7.24517e-05p
Cg28 n0070 VGND 0.00257632p
Cg29 n0075 VGND 8.04461e-05p
Cg30 n0073 VGND 0.000106541p
Cg31 clk_root_out VGND 0.000146182p
Cg32 n0080 VGND 0.000642985p
Cg33 n0079 VGND 0.0006848p
Cg34 n0078 VGND 0.00128698p
Cg35 n0077 VGND 0.000129791p
Cg36 cks[0] VGND 3.5247e-05p
Cg37 cks[2] VGND 0.000209918p
Cg38 cks[1] VGND 1.97954e-05p
Cg39 ckm[0] VGND 0.00038162p
Cg40 clk_leaf0_out VGND 0.000145145p
Cg41 n0083 VGND 0.000502962p
Cg42 n0082 VGND 0.000779312p
Cg43 n0081 VGND 0.00042937p
Cg44 n0084 VGND 0.000544615p
Cg46 cks[3] VGND 0.000106615p
Cg47 ckm[1] VGND 0.00013354p
Cg48 ckm[2] VGND 8.34426e-05p
Cg49 clk_leaf1_out VGND 7.88611e-05p
Cg50 n0086 VGND 0.00045211p
Cg51 n0085 VGND 0.00047593p
Cg52 n0087 VGND 0.000213048p
Cg53 en VGND 0.0018031p
Cg54 n0037 VGND 0.000328151p
Cg56 n0007 VGND 1.81917e-05p
Cg57 n0011 VGND 4.87547e-05p
Cg59 n0096 VGND 0.000475131p
Cg60 n0095 VGND 0.000283465p
Cg61 n0094 VGND 0.000252802p
Cg62 n0093 VGND 0.00188885p
Cg63 n0057 VGND 0.000133643p
Cg64 master[0] VGND 0.000133643p
Cg65 n0060 VGND 0.000193233p
Cg66 master[1] VGND 0.000193233p
Cg67 n0063 VGND 0.000298102p
Cg68 master[2] VGND 0.000298102p
Cg69 n0066 VGND 0.000204083p
Cg70 master[3] VGND 0.000204083p
Cg71 rst_n VGND 0.00172354p
Cg72 n0043 VGND 7.55042e-05p
Cg73 n0017 VGND 4.82551e-05p
Cg74 n0029 VGND 0.00116952p
Cg76 n0099 VGND 0.00133576p
Cg77 n0098 VGND 0.000381308p
Cg78 n0100 VGND 0.00191136p
Cg79 q0 VGND 0.000767491p
Cg80 n0026 VGND 0.00013503p
Cg81 n0038 VGND 0.000222116p
Cg82 n0008 VGND 1.51828e-05p
Cg83 n0004 VGND 0.00023783p
Cg85 slave[0] VGND 0.000272359p
Cg86 n0104 VGND 0.00124195p
Cg87 n0103 VGND 0.00037444p
Cg88 n0102 VGND 0.000475045p
Cg89 n0101 VGND 0.000712928p
Cg90 q1 VGND 0.000792985p
Cg91 n0039 VGND 4.0151e-05p
Cg92 n0025 VGND 0.000104048p
Cg93 n0012 VGND 0.000656319p
Cg95 n0105 VGND 0.000860635p
Cg96 n0107 VGND 0.000878443p
Cg97 n0106 VGND 0.000145573p
Cg98 q2 VGND 0.00067084p
Cg100 n0023 VGND 1.26464e-05p
Cg102 n0019 VGND 0.000111806p
Cg103 slave[2] VGND 0.0003931p
Cg104 n0110 VGND 0.000725228p
Cg105 n0109 VGND 0.00086623p
Cg106 n0108 VGND 0.00110578p
Cg107 q3 VGND 0.0007275p
Cg108 n0033 VGND 1.19219e-05p
Cg109 n0027 VGND 0.000484193p
Cg110 slave[3] VGND 0.000257118p
Cg111 n0112 VGND 0.000597976p
Cg112 n0111 VGND 0.00108648p
Cc0 n0000 n0004 2.30878e-06p
Cc1 n0000 n0042 4.95146e-05p
Cc2 n0000 n0043 1.53654e-05p
Cc3 n0000 n0070 3.05486e-05p
Cc4 n0000 n0083 0.000142586p
Cc5 n0001 n0042 1.41291e-05p
Cc6 n0001 _00_[1] 0.000177417p
Cc8 n0001 n0070 6.41328e-05p
Cc9 n0001 n0083 8.74947e-07p
Cc10 n0001 n0099 1.56483e-05p
Cc11 n0002 _00_[1] 8.24328e-05p
Cc13 n0004 n0011 4.13041e-05p
Cc14 n0004 n0070 4.46758e-06p
Cc15 n0004 n0094 3.04619e-05p
Cc16 n0004 n0095 1.77521e-05p
Cc17 n0004 n0098 3.11666e-05p
Cc18 n0007 n0008 1.09551e-05p
Cc20 n0007 n0079 3.18093e-05p
Cc22 n0008 n0079 1.5147e-05p
Cc23 n0009 n0012 2.51492e-05p
Cc25 n0009 ckm[0] 2.2645e-05p
Cc26 n0009 n0070 1.40385e-05p
Cc27 n0009 n0083 7.65861e-05p
Cc29 n0009 n0094 0.000117376p
Cc30 n0009 n0095 0.00010592p
Cc31 n0009 n0098 1.05298e-05p
Cc32 n0009 n0100 1.07048e-05p
Cc33 n0009 n0103 0.000107496p
Cc34 n0011 n0098 2.65078e-05p
Cc35 n0011 n0100 1.53698e-06p
Cc37 n0012 n0077 6.48882e-05p
Cc38 n0012 n0095 0.000309069p
Cc39 n0012 n0096 9.39797e-05p
Cc40 n0012 n0102 2.11196e-05p
Cc41 n0016 n0017 1.1718e-05p
Cc42 n0016 n0029 9.80242e-07p
Cc43 n0016 n0071 2.16355e-05p
Cc44 n0016 n0109 0.000128094p
Cc45 n0017 _00_[1] 1.20285e-05p
Cc46 n0017 n0109 9.70783e-06p
Cc47 n0019 n0021 0.000185462p
Cc49 n0020 _00_[1] 0.000114584p
Cc50 n0020 _00_[2] 2.2694e-05p
Cc52 n0021 n0109 0.000101873p
Cc53 n0023 n0027 2.65667e-05p
Cc54 n0023 n0042 6.50727e-05p
Cc55 n0025 n0026 1.92172e-05p
Cc56 n0025 n0042 0.000122378p
Cc57 n0026 n0030 8.51299e-05p
Cc58 n0026 n0042 6.50586e-05p
Cc59 n0027 n0029 3.3143e-05p
Cc60 n0027 n0030 0.000205659p
Cc61 n0027 n0034 3.66439e-05p
Cc62 n0027 n0037 0.000201831p
Cc63 n0027 n0039 1.25464e-05p
Cc64 n0027 n0042 8.18976e-05p
Cc66 n0027 q1 1.61704e-05p
Cc67 n0027 n0105 4.18215e-06p
Cc68 n0027 n0108 8.45833e-05p
Cc69 n0027 n0109 4.28482e-06p
Cc70 n0027 n0110 1.79463e-05p
Cc71 n0029 n0034 6.01383e-05p
Cc72 n0029 n0035 0.000131893p
Cc73 n0029 n0060 3.6114e-05p
Cc74 n0029 cks[1] 2.58757e-05p
Cc75 n0029 n0063 3.98472e-05p
Cc76 n0029 n0071 3.23874e-05p
Cc77 n0029 n0078 4.84662e-06p
Cc78 n0029 n0079 4.06318e-05p
Cc80 n0029 q2 3.47752e-05p
Cc81 n0029 q3 2.38879e-05p
Cc82 n0029 n0108 0.000201264p
Cc83 n0029 n0110 7.58194e-05p
Cc84 n0029 n0111 2.71705e-05p
Cc85 n0030 n0035 3.11851e-06p
Cc86 n0030 n0038 5.25894e-05p
Cc87 n0030 n0042 2.32423e-05p
Cc88 n0030 q0 6.01342e-06p
Cc89 n0030 q1 1.21418e-06p
Cc91 n0030 n0111 7.13655e-06p
Cc92 n0033 n0034 1.38105e-05p
Cc93 n0033 q2 3.78676e-06p
Cc94 n0034 n0060 0.000167076p
Cc95 n0034 n0063 6.92705e-05p
Cc96 n0034 cks[2] 0.000172143p
Cc97 n0034 q2 1.47978e-05p
Cc98 n0034 n0108 0.000320579p
Cc99 n0034 n0110 2.99287e-05p
Cc100 n0035 q2 6.34917e-05p
Cc101 n0035 q3 1.66869e-05p
Cc102 n0035 n0111 7.57352e-06p
Cc103 n0037 n0039 6.3657e-05p
Cc104 n0037 n0042 3.34601e-05p
Cc105 n0037 q1 2.27504e-05p
Cc106 n0037 n0102 4.37063e-06p
Cc108 n0037 n0108 0.000239489p
Cc109 n0037 n0109 3.73455e-05p
Cc111 n0038 q1 4.70697e-06p
Cc113 n0039 n0042 2.57986e-05p
Cc114 n0042 n0043 1.53654e-05p
Cc115 n0042 n0070 5.54215e-06p
Cc116 n0042 q1 5.13699e-06p
Cc117 n0042 n0098 1.42115e-05p
Cc118 n0042 n0105 2.1667e-05p
Cc119 n0042 n0107 0.000164646p
Cc120 n0042 n0109 0.000531105p
Cc121 n0043 n0070 2.44152e-06p
Cc122 n0043 n0109 1.86027e-05p
Cc123 _00_[0] ckm[0] 8.75785e-05p
Cc124 _00_[0] n0070 4.84443e-05p
Cc125 _00_[0] n0079 0.000103493p
Cc126 _00_[0] n0082 1.00846e-05p
Cc127 _00_[0] n0083 0.000184946p
Cc129 _00_[0] n0103 6.85362e-05p
Cc130 ckm[0] n0093 4.30751e-05p
Cc131 _00_[1] n0099 8.92089e-05p
Cc132 _00_[1] n0109 2.99735e-05p
Cc133 ckm[1] _00_[2] 0.000141782p
Cc134 _00_[3] n0066 7.48797e-05p
Cc135 _00_[3] n0111 6.65668e-05p
Cc136 n0057 n0070 6.08431e-06p
Cc137 n0057 n0079 3.39325e-05p
Cc138 n0057 n0081 3.34353e-05p
Cc139 n0057 n0082 9.18559e-06p
Cc141 cks[0] n0079 5.43409e-05p
Cc142 n0060 n0078 9.4507e-06p
Cc143 n0060 n0079 1.38105e-05p
Cc144 n0060 n0080 1.47102e-05p
Cc145 cks[1] n0078 1.43832e-05p
Cc146 cks[1] n0079 2.94603e-06p
Cc147 n0063 cks[3] 5.46286e-05p
Cc148 n0063 n0080 4.15008e-05p
Cc149 cks[2] n0070 8.70662e-06p
Cc150 cks[2] n0078 4.39045e-06p
Cc151 cks[2] n0079 3.23014e-05p
Cc152 cks[2] n0080 0.000125461p
Cc154 n0070 n0078 4.30983e-06p
Cc155 n0070 n0079 2.75539e-05p
Cc156 n0070 n0083 0.000108768p
Cc158 n0070 n0109 1.01408e-05p
Cc159 n0071 n0078 5.04829e-06p
Cc160 n0077 n0096 9.35753e-06p
Cc161 n0077 n0102 0.000118166p
Cc162 n0079 n0083 7.655e-05p
Cc164 n0079 n0095 3.18093e-05p
Cc167 n0079 n0109 9.2063e-06p
Cc168 n0080 n0085 5.64896e-05p
Cc169 n0080 n0087 3.62414e-05p
Cc170 q0 q1 0.000262738p
Cc171 q1 q2 0.00117761p
Cc172 q1 q3 4.28777e-05p
Cc173 q1 n0112 8.26043e-06p
Cc174 q2 q3 0.000277892p
Cc175 q2 n0111 1.89338e-05p
Cc176 q2 n0112 2.39726e-06p
Cc177 n0093 n0100 0.000875686p
Cc178 n0094 n0098 1.53654e-05p
Cc179 n0094 n0100 7.53425e-06p
Cc180 n0095 n0098 3.58525e-06p
Cc181 n0095 n0103 4.04348e-05p
Cc182 n0096 n0102 6.75138e-05p
Cc183 n0096 n0103 2.65831e-05p
Cc184 n0096 n0109 8.62625e-06p
Cc185 n0098 n0109 2.41227e-05p
Cc186 n0099 n0109 0.000145941p
Cc187 n0110 n0112 5.9821e-06p
.ends counter_postroute
