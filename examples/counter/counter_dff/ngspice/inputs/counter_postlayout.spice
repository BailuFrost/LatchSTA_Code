* Final routed counter: transistor cell models plus distributed SPEF RC.
* SPEF C_UNIT pF; R_UNIT ohm; cell pin capacitance is provided by MOS models.
.subckt counter_postlayout clk en rst_n count0 count1 count2 count3 vdd vss
* _11_
Xcell00 n0008 n0009 n0010 vss vss vdd vdd n0011 sky130_fd_sc_hd__mux2_1
* _12_
Xcell01 n0012 n0013 n0014 vss vss vdd vdd n0015 sky130_fd_sc_hd__mux2_1
* _13_
Xcell02 n0016 n0017 n0018 vss vss vdd vdd n0019 sky130_fd_sc_hd__mux2_1
* _14_
Xcell03 n0020 n0021 n0022 vss vss vdd vdd n0023 sky130_fd_sc_hd__mux2_1
* _15_
Xcell04 n0024 n0025 vss vss vdd vdd n0026 sky130_fd_sc_hd__and2_1
* _16_
Xcell05 n0027 n0028 vss vss vdd vdd n0029 sky130_fd_sc_hd__and2_1
* _17_
Xcell06 n0030 n0031 vss vss vdd vdd n0032 sky130_fd_sc_hd__xor2_1
* _18_
Xcell07 n0033 n0034 vss vss vdd vdd n0035 sky130_fd_sc_hd__xor2_1
* _19_
Xcell08 n0036 n0037 vss vss vdd vdd n0038 sky130_fd_sc_hd__xor2_1
* _20_
Xcell09 n0039 vss vss vdd vdd n0040 sky130_fd_sc_hd__inv_1
* clkbuf_0_clk
Xcell10 n0042 vss vss vdd vdd n0043 sky130_fd_sc_hd__clkbuf_4
* clkbuf_1_0__f_clk
Xcell11 n0044 vss vss vdd vdd n0045 sky130_fd_sc_hd__clkbuf_4
* clkbuf_1_1__f_clk
Xcell12 n0046 vss vss vdd vdd n0047 sky130_fd_sc_hd__clkbuf_4
* count_o_reg[0]
Xcell13 n0064 n0065 n0067 vss vss vdd vdd n0066 sky130_fd_sc_hd__dfrtp_1
* count_o_reg[1]
Xcell14 n0068 n0069 n0071 vss vss vdd vdd n0070 sky130_fd_sc_hd__dfrtp_1
* count_o_reg[2]
Xcell15 n0072 n0073 n0075 vss vss vdd vdd n0074 sky130_fd_sc_hd__dfrtp_1
* count_o_reg[3]
Xcell16 n0076 n0077 n0079 vss vss vdd vdd n0078 sky130_fd_sc_hd__dfrtp_1
Rwire0 n0029 n0007 16.2529
Rwire1 n0007 n0025 13.5904
Rwire2 n0007 n0034 23.1728
Rwire3 n0026 n0037 27.4561
Rwire4 n0040 n0013 30.6401
Rwire5 n0032 n0009 29.5323
Rwire6 n0035 n0017 28.5653
Rwire7 n0038 n0021 31.6705
Rwire8 n0011 n0069 30.122
Rwire9 n0015 n0065 27.5954
Rwire10 n0019 n0073 37.5383
Rwire11 n0023 n0077 30.6712
Rwire12 clk n0041 13.3322
Rwire13 n0041 n0042 11.7578
Rwire14 n0043 n0050 11.7578
Rwire15 n0050 n0048 16.1502
Rwire16 n0048 n0044 13.6989
Rwire17 n0050 n0049 5.65125
Rwire18 n0049 n0046 13.0358
Rwire19 n0045 n0051 22.7253
Rwire20 n0051 n0068 16.918
Rwire21 n0051 n0064 24.0361
Rwire22 n0047 n0052 15.8088
Rwire23 n0052 n0072 16.9851
Rwire24 n0052 n0076 14.005
Rwire25 n0066 n0055 23.4045
Rwire26 n0055 n0031 11.589
Rwire27 n0055 n0053 6.60361
Rwire28 n0053 n0028 11.7578
Rwire29 n0053 count0 4.20737
Rwire30 n0066 n0054 16.918
Rwire31 n0054 n0012 16.4965
Rwire32 n0054 n0039 15.4337
Rwire33 n0070 n0057 11.589
Rwire34 n0057 n0058 1.44679
Rwire35 n0058 n0008 14.8678
Rwire36 n0058 n0056 4.73876
Rwire37 n0056 n0030 13.5904
Rwire38 n0056 n0027 15.5589
Rwire39 n0057 count1 30.191
Rwire40 n0074 n0061 13.1745
Rwire41 n0061 n0059 2.99004
Rwire42 n0059 n0024 11.589
Rwire43 n0059 count2 21.3314
Rwire44 n0061 n0060 8.47603
Rwire45 n0060 n0016 13.0358
Rwire46 n0060 n0033 15.3071
Rwire47 n0078 n0063 14.0003
Rwire48 n0063 n0062 0.168792
Rwire49 n0062 n0020 17.9167
Rwire50 n0062 count3 3.91804
Rwire51 n0063 n0036 11.589
Rwire52 en n0080 6.82114
Rwire53 n0080 n0014 12.1677
Rwire54 n0080 n0081 16.0594
Rwire55 n0081 n0010 17.4986
Rwire56 n0081 n0082 9.72179
Rwire57 n0082 n0022 13.5904
Rwire58 n0082 n0018 20.4054
Rwire59 rst_n n0067 5.74255
Rwire60 n0067 n0083 8.40345
Rwire61 n0083 n0084 2.41604
Rwire62 n0084 n0075 0.168792
Rwire63 n0084 n0079 7.8876
Rwire64 n0083 n0071 6.35434
Cwire0 n0034 vss 0.000355166p
Cwire1 n0025 vss 2.91417e-05p
Cwire2 n0029 vss 0.000256847p
Cwire3 n0007 vss 0.000641154p
Cwire4 n0037 vss 0.00015715p
Cwire5 n0026 vss 0.00015715p
Cwire6 n0013 vss 0.000261735p
Cwire7 n0040 vss 0.000261735p
Cwire8 n0009 vss 0.000182743p
Cwire9 n0032 vss 0.000182743p
Cwire10 n0017 vss 0.000245955p
Cwire11 n0035 vss 0.000245955p
Cwire12 n0021 vss 0.000375304p
Cwire13 n0038 vss 0.000375304p
Cwire14 n0069 vss 0.000361489p
Cwire15 n0011 vss 0.000361489p
Cwire16 n0065 vss 0.000256324p
Cwire17 n0015 vss 0.000256324p
Cwire18 n0073 vss 0.000728916p
Cwire19 n0019 vss 0.000728916p
Cwire20 n0077 vss 0.00046147p
Cwire21 n0023 vss 0.00046147p
Cwire22 clk vss 0.0020788p
Cwire23 n0041 vss 0.0020788p
Cwire24 n0046 vss 4.75232e-05p
Cwire25 n0044 vss 9.83271e-05p
Cwire26 n0049 vss 0.000558237p
Cwire27 n0048 vss 0.000666912p
Cwire28 n0050 vss 0.0010793p
Cwire29 n0064 vss 0.000759632p
Cwire30 n0068 vss 0.000131901p
Cwire31 n0045 vss 0.000347588p
Cwire32 n0051 vss 0.00123912p
Cwire33 n0076 vss 9.75037e-05p
Cwire34 n0072 vss 0.000210609p
Cwire35 n0047 vss 0.000286588p
Cwire36 n0052 vss 0.0005947p
Cwire37 count0 vss 0.00135727p
Cwire38 n0039 vss 0.000141017p
Cwire39 n0012 vss 0.000145905p
Cwire40 n0066 vss 0.000729067p
Cwire41 n0054 vss 0.000632179p
Cwire42 n0053 vss 0.00158005p
Cwire43 n0055 vss 0.00060659p
Cwire44 count1 vss 0.0015919p
Cwire45 n0027 vss 0.000117391p
Cwire46 n0030 vss 5.62717e-05p
Cwire47 n0008 vss 0.000105644p
Cwire48 n0056 vss 0.000315526p
Cwire49 n0058 vss 0.000339126p
Cwire50 n0057 vss 0.00168352p
Cwire51 count2 vss 0.000866567p
Cwire52 n0033 vss 0.000143127p
Cwire53 n0016 vss 2.99876e-05p
Cwire54 n0074 vss 4.82479e-05p
Cwire55 n0060 vss 0.000399636p
Cwire56 n0059 vss 0.00102551p
Cwire57 n0061 vss 0.000433716p
Cwire58 count3 vss 0.00117007p
Cwire59 n0020 vss 0.000156657p
Cwire60 n0078 vss 0.000112508p
Cwire61 n0062 vss 0.00132672p
Cwire62 n0063 vss 0.000112508p
Cwire63 en vss 0.00149348p
Cwire64 n0018 vss 0.00029351p
Cwire65 n0022 vss 6.94134e-05p
Cwire66 n0010 vss 0.000200785p
Cwire67 n0014 vss 2.06324e-05p
Cwire68 n0082 vss 0.00070436p
Cwire69 n0081 vss 0.00115993p
Cwire70 n0080 vss 0.00213183p
Cwire71 rst_n vss 0.00130789p
Cwire72 n0071 vss 0.000244p
Cwire73 n0079 vss 0.000285565p
Cwire74 n0067 vss 0.00157048p
Cwire75 n0084 vss 0.000380247p
Cwire76 n0083 vss 0.000601266p
Cwire77 n0021 n0025 2.29888e-05p
Cwire78 n0017 n0034 0.000147332p
Cwire79 n0025 count2 0.000115157p
Cwire80 n0034 count3 1.41341e-05p
Cwire81 n0020 n0025 0.000112367p
Cwire82 n0020 n0034 6.28413e-05p
Cwire83 n0033 n0034 6.52382e-05p
Cwire84 n0007 n0061 2.8322e-05p
Cwire85 n0025 n0059 1.00901e-05p
Cwire86 n0034 n0060 0.000177273p
Cwire87 n0007 n0060 3.32181e-05p
Cwire88 n0021 n0037 0.000175341p
Cwire89 n0037 count3 4.42987e-06p
Cwire90 n0012 n0013 0.000240718p
Cwire91 n0013 n0039 0.000109935p
Cwire92 n0013 n0041 8.41807e-05p
Cwire93 n0008 n0009 7.73687e-05p
Cwire94 n0009 n0010 6.72556e-05p
Cwire95 n0009 n0053 4.31703e-05p
Cwire96 n0009 n0056 0.000194577p
Cwire97 n0009 n0082 5.54078e-05p
Cwire98 n0016 n0017 6.50586e-05p
Cwire99 n0021 count2 1.37189e-05p
Cwire100 n0021 count3 5.22654e-06p
Cwire101 n0020 n0021 0.000310685p
Cwire102 n0069 n0071 3.20069e-06p
Cwire103 n0069 n0081 7.16754e-05p
Cwire104 n0049 n0073 5.38371e-05p
Cwire105 n0073 n0079 0.000244592p
Cwire106 n0018 n0077 1.79672e-05p
Cwire107 n0041 n0064 4.52469e-05p
Cwire108 n0041 n0051 1.93781e-05p
Cwire109 n0046 n0052 4.45999e-05p
Cwire110 n0048 n0064 4.70005e-05p
Cwire111 n0048 n0051 0.000255969p
Cwire112 n0054 n0064 1.53312e-05p
Cwire113 n0068 n0081 0.000482072p
Cwire114 n0064 n0083 6.07304e-07p
Cwire115 count0 count1 7.93958e-06p
Cwire116 n0012 n0067 3.0884e-05p
Cwire117 n0012 n0080 1.66626e-05p
Cwire118 n0030 n0055 6.50727e-05p
Cwire119 n0055 n0071 4.33655e-05p
Cwire120 n0055 n0083 0.000289914p
Cwire121 n0027 n0053 5.044e-05p
Cwire122 n0030 n0053 0.000118166p
Cwire123 n0053 n0056 6.08697e-06p
Cwire124 n0054 n0083 0.00016096p
Cwire125 count1 count2 7.93958e-06p
Cwire126 n0008 n0010 6.15108e-05p
Cwire127 n0027 n0082 5.19216e-05p
Cwire128 n0056 n0082 1.8906e-05p
Cwire129 count2 count3 7.93958e-06p
Cwire130 n0016 n0018 5.0715e-05p
Cwire131 n0061 n0082 1.95129e-05p
Cwire132 n0020 n0059 1.32618e-05p
Cwire133 n0022 n0059 5.04829e-06p
Cwire134 n0018 n0060 0.000120099p
Cwire135 n0060 n0082 1.35317e-05p
Cwire136 n0020 n0022 4.89251e-05p
Cwire137 n0067 n0080 0.000615492p
.ends counter_postlayout
