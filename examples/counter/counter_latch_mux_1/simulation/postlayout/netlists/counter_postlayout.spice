* Routed transistor circuit with distributed OpenRCX RC and explicit coupling.
* Ports: four inputs, supply/ground, count[3:0].
.subckt counter_postlayout clk_1 clk_2 rst_n en VPWR VGND count3 count2 count1 count0
x_11_ n0000 n0001 n0002 VGND VGND VPWR VPWR n0003 sky130_fd_sc_hd__mux2_1
x_12_ n0004 n0005 n0006 VGND VGND VPWR VPWR n0007 sky130_fd_sc_hd__mux2_1
x_15_ n0008 n0009 n0010 VGND VGND VPWR VPWR n0011 sky130_fd_sc_hd__and3_1
x_16_ n0012 n0013 n0014 VGND VGND VPWR VPWR n0015 sky130_fd_sc_hd__and3_1
x_17_ n0016 n0017 VGND VGND VPWR VPWR n0018 sky130_fd_sc_hd__xor2_1
x_18_ n0019 n0020 VGND VGND VPWR VPWR n0021 sky130_fd_sc_hd__xor2_1
x_19_ n0022 n0023 VGND VGND VPWR VPWR n0024 sky130_fd_sc_hd__xor2_1
x_20_ n0025 VGND VGND VPWR VPWR n0026 sky130_fd_sc_hd__inv_1
xbit3_enable n0027 n0028 VGND VGND VPWR VPWR n0029 sky130_fd_sc_hd__and2_4
xclkbuf_0_clk_1 n0032 VGND VGND VPWR VPWR n0033 sky130_fd_sc_hd__clkbuf_4
xclkbuf_0_clk_2 n0034 VGND VGND VPWR VPWR n0035 sky130_fd_sc_hd__clkbuf_4
xclkbuf_1_0__f_clk_1 n0036 VGND VGND VPWR VPWR n0037 sky130_fd_sc_hd__clkbuf_4
xclkbuf_1_0__f_clk_2 n0038 VGND VGND VPWR VPWR n0039 sky130_fd_sc_hd__clkbuf_4
xclkbuf_1_1__f_clk_1 n0040 VGND VGND VPWR VPWR n0041 sky130_fd_sc_hd__clkbuf_4
xclkbuf_1_1__f_clk_2 n0042 VGND VGND VPWR VPWR n0043 sky130_fd_sc_hd__clkbuf_4
xreset_release_buf1 n0072 VGND VGND VPWR VPWR n0073 sky130_fd_sc_hd__buf_1
xstate_phi1_bit0 n0085 n0086 n0088 VGND VGND VPWR VPWR n0087 sky130_fd_sc_hd__dlrtp_1
xstate_phi1_bit1 n0089 n0090 n0092 VGND VGND VPWR VPWR n0091 sky130_fd_sc_hd__dlrtp_1
xstate_phi1_bit2 n0093 n0094 n0096 VGND VGND VPWR VPWR n0095 sky130_fd_sc_hd__dlrtp_1
xstate_phi1_bit3 n0097 n0098 n0100 VGND VGND VPWR VPWR n0099 sky130_fd_sc_hd__dlrtp_1
xstate_phi1_toggle2 n0101 n0102 n0104 VGND VGND VPWR VPWR n0103 sky130_fd_sc_hd__dlrtp_1
xstate_phi1_toggle3 n0105 n0106 n0108 VGND VGND VPWR VPWR n0107 sky130_fd_sc_hd__dlrtp_1
xstate_phi2_bit0 n0109 n0110 n0112 VGND VGND VPWR VPWR n0111 sky130_fd_sc_hd__dlrtp_4
xstate_phi2_bit1 n0113 n0114 n0116 VGND VGND VPWR VPWR n0115 sky130_fd_sc_hd__dlrtp_4
xstate_phi2_bit2 n0117 n0118 n0120 VGND VGND VPWR VPWR n0119 sky130_fd_sc_hd__dlrtp_2
xstate_phi2_bit3 n0121 n0122 n0124 VGND VGND VPWR VPWR n0123 sky130_fd_sc_hd__dlrtp_2
* Interconnect resistances in ohms.
Rwire0 n0026 n0005 34.9072
Rwire1 n0018 n0001 37.6676
Rwire2 n0003 n0089 34.9002
Rwire3 n0007 n0085 34.2118
Rwire4 n0011 n0028 21.4883
Rwire5 clk_1 n0030 13.0154
Rwire6 n0030 n0032 13.7491
Rwire7 clk_2 n0031 28.6035
Rwire8 n0031 n0034 15.0271
Rwire9 n0033 n0047 16.1364
Rwire10 n0047 n0044 12.5109
Rwire11 n0044 n0036 13.7491
Rwire12 n0033 n0045 12.3839
Rwire13 n0045 n0046 2.9599
Rwire14 n0046 n0040 11.6183
Rwire15 n0035 n0051 13.7491
Rwire16 n0051 n0048 3.7474
Rwire17 n0048 n0049 6.32146
Rwire18 n0049 n0038 13.7491
Rwire19 n0048 n0050 5.78603
Rwire20 n0050 n0042 13.7491
Rwire21 n0037 n0053 16.0973
Rwire22 n0053 n0052 0.578717
Rwire23 n0052 n0090 28.2791
Rwire24 n0052 n0094 30.4205
Rwire25 n0053 n0086 9.24915
Rwire26 n0039 n0054 18.3548
Rwire27 n0054 n0114 19.3184
Rwire28 n0054 n0110 18.9764
Rwire29 n0041 n0056 12.7456
Rwire30 n0056 n0102 32.8819
Rwire31 n0056 n0055 6.74725
Rwire32 n0055 n0098 22.3968
Rwire33 n0055 n0106 13.7491
Rwire34 n0043 n0057 23.3462
Rwire35 n0057 n0122 25.4401
Rwire36 n0057 n0118 17.6896
Rwire37 n0111 n0060 9.24915
Rwire38 n0060 n0058 10.383
Rwire39 n0058 n0004 20.5732
Rwire40 n0058 n0025 17.2857
Rwire41 n0060 n0059 8.85855
Rwire42 n0059 n0061 11.2607
Rwire43 n0061 n0062 5.56926
Rwire44 n0062 count0 14.8269
Rwire45 n0062 n0017 21.6824
Rwire46 n0061 n0010 14.569
Rwire47 n0059 n0013 16.1364
Rwire48 n0115 n0065 15.0271
Rwire49 n0065 n0063 10.8998
Rwire50 n0063 n0016 14.4094
Rwire51 n0063 count1 24.6265
Rwire52 n0065 n0064 4.73876
Rwire53 n0064 n0000 18.3548
Rwire54 n0064 n0012 16.7198
Rwire55 n0115 n0009 20.8855
Rwire56 n0119 n0066 24.8995
Rwire57 n0066 n0067 17.9997
Rwire58 n0067 count2 26.0443
Rwire59 n0067 n0008 9.24915
Rwire60 n0066 n0093 16.1364
Rwire61 n0123 n0068 26.6265
Rwire62 n0068 count3 40.4528
Rwire63 n0068 n0097 9.24915
Rwire64 en n0069 36.7375
Rwire65 n0069 n0070 17.2284
Rwire66 n0070 n0071 5.778
Rwire67 n0071 n0006 29.4233
Rwire68 n0071 n0002 9.82786
Rwire69 n0070 n0014 20.1439
Rwire70 n0069 n0027 9.24915
Rwire71 n0021 n0117 36.7356
Rwire72 n0024 n0121 38.3966
Rwire73 n0087 n0109 32.548
Rwire74 n0091 n0113 31.0235
Rwire75 n0095 n0019 34.7608
Rwire76 n0099 n0022 39.9154
Rwire77 n0103 n0020 20.355
Rwire78 n0107 n0023 30.4689
Rwire79 rst_n n0074 1.6488
Rwire80 n0074 n0075 50.6241
Rwire81 n0075 n0072 16.1364
Rwire82 n0073 n0076 35.4455
Rwire83 n0076 n0077 13.5713
Rwire84 n0077 n0078 4.11588
Rwire85 n0078 n0088 17.824
Rwire86 n0078 n0079 6.6074
Rwire87 n0079 n0092 20.8779
Rwire88 n0079 n0116 13.7491
Rwire89 n0077 n0112 14.4725
Rwire90 n0076 n0080 6.26943
Rwire91 n0080 n0104 9.24915
Rwire92 n0080 n0081 10.2437
Rwire93 n0081 n0082 5.47156
Rwire94 n0082 n0083 6.81502
Rwire95 n0083 n0084 9.29792
Rwire96 n0084 n0100 22.5727
Rwire97 n0084 n0124 9.97254
Rwire98 n0083 n0108 14.4725
Rwire99 n0082 n0096 13.7491
Rwire100 n0081 n0120 14.4725
Rwire101 n0015 n0101 40.8586
Rwire102 n0029 n0105 20.8855
* Interconnect capacitances in farads; coupling is NOT grounded.
Cwire0 n0005 0 4.75503e-16
Cwire1 n0026 0 4.75503e-16
Cwire2 n0001 0 3.89296e-16
Cwire3 n0018 0 3.89296e-16
Cwire4 n0089 0 3.06472e-16
Cwire5 n0003 0 3.06472e-16
Cwire6 n0085 0 3.58505e-16
Cwire7 n0007 0 3.58505e-16
Cwire8 n0028 0 1.00703e-16
Cwire9 n0011 0 1.00703e-16
Cwire10 clk_1 0 1.54666e-15
Cwire11 n0030 0 1.54666e-15
Cwire12 clk_2 0 7.61658e-16
Cwire13 n0034 0 3.79564e-17
Cwire14 n0031 0 7.99615e-16
Cwire15 n0040 0 9.7425e-17
Cwire16 n0033 0 2.64026e-16
Cwire17 n0046 0 2.2715e-16
Cwire18 n0045 0 2.72162e-16
Cwire19 n0044 0 1.24521e-15
Cwire20 n0047 0 1.3668e-15
Cwire21 n0050 0 1.00335e-15
Cwire22 n0049 0 1.17562e-15
Cwire23 n0048 0 2.19209e-15
Cwire24 n0051 0 1.31175e-17
Cwire25 n0094 0 7.85042e-16
Cwire26 n0090 0 3.62927e-16
Cwire27 n0037 0 2.73948e-16
Cwire28 n0052 0 1.171e-15
Cwire29 n0053 0 2.96982e-16
Cwire30 n0110 0 1.6554e-16
Cwire31 n0114 0 2.31571e-16
Cwire32 n0039 0 2.71438e-16
Cwire33 n0054 0 6.68549e-16
Cwire34 n0098 0 3.23032e-16
Cwire35 n0102 0 4.22675e-16
Cwire36 n0041 0 2.233e-16
Cwire37 n0055 0 3.84894e-16
Cwire38 n0056 0 7.07836e-16
Cwire39 n0118 0 1.63923e-16
Cwire40 n0122 0 4.7114e-16
Cwire41 n0043 0 6.77199e-16
Cwire42 n0057 0 1.31226e-15
Cwire43 count0 0 2.63761e-16
Cwire44 n0013 0 1.36092e-16
Cwire45 n0010 0 4.70334e-17
Cwire46 n0017 0 1.96604e-16
Cwire47 n0025 0 1.49834e-16
Cwire48 n0004 0 3.07671e-16
Cwire49 n0062 0 5.82588e-16
Cwire50 n0061 0 5.97126e-16
Cwire51 n0059 0 8.35246e-16
Cwire52 n0058 0 8.14525e-16
Cwire53 n0060 0 6.28305e-16
Cwire54 count1 0 4.74863e-16
Cwire55 n0009 0 1.52455e-16
Cwire56 n0012 0 9.95714e-17
Cwire57 n0000 0 1.99512e-16
Cwire58 n0016 0 1.38569e-16
Cwire59 n0115 0 1.96922e-16
Cwire60 n0064 0 4.63385e-16
Cwire61 n0063 0 8.54842e-16
Cwire62 n0065 0 4.50179e-16
Cwire63 count2 0 5.54978e-16
Cwire64 n0093 0 9.65367e-17
Cwire65 n0119 0 6.54574e-16
Cwire66 n0067 0 9.9902e-16
Cwire67 n0066 0 1.19515e-15
Cwire68 count3 0 9.85697e-16
Cwire69 n0123 0 3.54749e-16
Cwire70 n0068 0 1.34045e-15
Cwire71 en 0 6.47837e-16
Cwire72 n0014 0 3.69592e-16
Cwire73 n0002 0 2.18332e-17
Cwire74 n0006 0 3.94798e-16
Cwire75 n0071 0 4.50395e-16
Cwire76 n0070 0 8.05314e-16
Cwire77 n0069 0 1.04979e-15
Cwire78 n0117 0 3.56676e-16
Cwire79 n0021 0 3.56676e-16
Cwire80 n0121 0 4.20115e-16
Cwire81 n0024 0 4.20115e-16
Cwire82 n0109 0 2.4167e-16
Cwire83 n0087 0 2.4167e-16
Cwire84 n0113 0 1.44313e-16
Cwire85 n0091 0 1.44313e-16
Cwire86 n0019 0 2.42673e-16
Cwire87 n0095 0 2.42673e-16
Cwire88 n0022 0 4.53113e-16
Cwire89 n0099 0 4.53113e-16
Cwire90 n0020 0 6.78468e-17
Cwire91 n0103 0 6.78468e-17
Cwire92 n0023 0 1.37346e-16
Cwire93 n0107 0 1.37346e-16
Cwire94 rst_n 0 4.17281e-17
Cwire95 n0072 0 1.0982e-16
Cwire96 n0075 0 1.44248e-15
Cwire97 n0074 0 1.37439e-15
Cwire98 n0120 0 3.73114e-17
Cwire99 n0108 0 5.81894e-17
Cwire100 n0124 0 3.20205e-17
Cwire101 n0100 0 1.53672e-16
Cwire102 n0112 0 2.99529e-17
Cwire103 n0092 0 2.48874e-16
Cwire104 n0088 0 1.55396e-16
Cwire105 n0073 0 5.26333e-16
Cwire106 n0084 0 3.78379e-16
Cwire107 n0083 0 4.66756e-16
Cwire108 n0082 0 4.17213e-16
Cwire109 n0081 0 5.05886e-16
Cwire110 n0080 0 6.9592e-16
Cwire111 n0079 0 4.42864e-16
Cwire112 n0078 0 5.34395e-16
Cwire113 n0077 0 7.95373e-16
Cwire114 n0076 0 1.53542e-15
Cwire115 n0101 0 5.73616e-16
Cwire116 n0015 0 5.73616e-16
Cwire117 n0105 0 1.13587e-16
Cwire118 n0029 0 1.13587e-16
Cwire119 n0000 n0006 1.14271e-16
Cwire120 n0000 n0071 1.12361e-16
Cwire121 n0001 n0017 5.56461e-17
Cwire122 n0001 n0070 5.69404e-17
Cwire123 n0001 n0113 1.27179e-16
Cwire124 n0004 n0006 2.58616e-17
Cwire125 n0004 n0085 2.91639e-17
Cwire126 n0005 n0025 2.48351e-17
Cwire127 n0006 n0085 1.51078e-16
Cwire128 n0006 n0089 1.84293e-17
Cwire129 n0006 n0110 1.08532e-16
Cwire130 n0006 n0114 4.418e-17
Cwire131 n0009 n0070 5.35415e-17
Cwire132 n0010 n0067 7.43087e-17
Cwire133 n0012 n0014 6.3657e-17
Cwire134 n0012 n0079 1.0761e-16
Cwire135 n0012 n0094 1.41307e-17
Cwire136 n0013 n0094 2.15118e-16
Cwire137 n0014 n0079 2.31921e-17
Cwire138 n0014 n0094 8.39131e-17
Cwire139 n0016 n0017 4.36811e-16
Cwire140 n0017 count1 3.19954e-16
Cwire141 n0019 n0081 1.42232e-16
Cwire142 n0019 n0082 1.63478e-16
Cwire143 n0019 n0117 6.62808e-17
Cwire144 n0020 n0081 2.32594e-17
Cwire145 n0022 n0023 5.39463e-17
Cwire146 n0022 n0068 5.35415e-17
Cwire147 n0022 n0083 3.77515e-17
Cwire148 n0022 n0100 6.80864e-17
Cwire149 n0022 n0121 3.25709e-16
Cwire150 n0028 n0067 1.88014e-17
Cwire151 n0028 n0070 1.14594e-16
Cwire152 n0030 n0031 1.23483e-16
Cwire153 n0030 n0049 3.68332e-17
Cwire154 n0030 count0 1.18103e-16
Cwire155 n0030 count1 1.33729e-16
Cwire156 n0030 n0061 7.86825e-18
Cwire157 n0030 n0069 2.30994e-17
Cwire158 n0030 n0075 1.71486e-16
Cwire159 n0031 n0048 7.12632e-18
Cwire160 n0031 count0 4.30092e-16
Cwire161 n0031 count1 4.22319e-16
Cwire162 n0031 n0061 2.23992e-16
Cwire163 n0031 n0062 1.27514e-16
Cwire164 n0031 n0069 1.36556e-17
Cwire165 n0034 n0094 4.47179e-17
Cwire166 n0034 n0101 3.82228e-17
Cwire167 n0040 n0056 3.39561e-17
Cwire168 n0044 n0049 2.48019e-16
Cwire169 n0044 n0061 5.39635e-18
Cwire170 n0045 n0102 1.3658e-18
Cwire171 n0046 n0056 9.528e-18
Cwire172 n0046 n0102 2.80655e-17
Cwire173 n0048 n0075 7.86825e-18
Cwire174 n0053 n0054 1.1957e-17
Cwire175 n0054 n0090 6.27782e-17
Cwire176 n0054 n0094 2.92707e-16
Cwire177 n0055 n0067 5.01524e-17
Cwire178 n0055 n0122 3.58185e-17
Cwire179 count0 count2 4.30092e-16
Cwire180 count1 n0074 2.79993e-17
Cwire181 count1 n0075 2.73012e-16
Cwire182 count2 count3 2.33961e-16
Cwire183 count2 n0061 2.07688e-17
Cwire184 count2 n0062 2.74478e-16
Cwire185 n0058 n0112 1.43698e-17
Cwire186 n0063 n0092 1.5324e-16
Cwire187 n0064 n0079 2.43156e-16
Cwire188 n0064 n0092 2.6046e-17
Cwire189 n0065 n0070 1.14594e-16
Cwire190 n0066 n0101 1.35288e-16
Cwire191 n0066 n0117 7.48232e-17
Cwire192 n0066 n0118 2.84758e-17
Cwire193 n0066 n0120 1.03403e-17
Cwire194 n0067 n0069 1.07496e-16
Cwire195 n0067 n0070 3.14121e-16
Cwire196 n0067 n0075 5.00217e-17
Cwire197 n0067 n0098 2.71542e-17
Cwire198 n0067 n0101 5.21584e-17
Cwire199 n0067 n0102 7.92658e-17
Cwire200 n0068 n0100 3.41139e-17
Cwire201 n0069 n0074 1.9546e-17
Cwire202 n0069 n0075 1.2321e-15
Cwire203 n0070 n0079 5.06953e-17
Cwire204 n0075 n0076 4.63514e-16
Cwire205 n0075 n0102 6.1116e-16
Cwire206 n0080 n0102 4.31539e-17
Cwire207 n0081 n0117 1.1223e-16
Cwire208 n0082 n0117 8.36586e-18
Cwire209 n0083 n0121 2.05332e-16
Cwire210 n0084 n0121 1.62594e-16
Cwire211 n0088 n0094 1.14271e-16
Cwire212 n0088 n0109 2.84758e-17
Cwire213 n0089 n0090 1.0128e-16
Cwire214 n0092 n0113 4.81015e-17
Cwire215 n0093 n0094 2.58757e-17
Cwire216 n0094 n0101 6.16253e-17
Cwire217 n0094 n0109 2.09463e-17
Cwire218 n0098 n0122 6.12656e-17
Cwire219 n0101 n0102 4.23647e-16
Cwire220 n0109 n0110 5.43124e-17
.ends counter_postlayout
